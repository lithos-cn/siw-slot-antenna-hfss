# Ansys Electronics Desktop project, version 2025.2
materials:
  vacuum: permittivity=1
  Rogers_5880: permittivity=2.2 dielectric_loss_tangent=0.0009
  pec: conductivity=1e+30

design HFSSDesign1 (HFSS, HFSS Terminal Network, model units mm)
geometry:
  Substrate [Rogers_5880] = box(corner=(0mm, 0mm, 0mm), size=(40mm, 17.2mm, 0.508mm))
  Ground = rectangle(corner=(0mm, 0mm, 0mm), x_size=40mm, y_size=17.2mm)
  AirBox [vacuum] = box(corner=(0mm, -4.3mm, -0.508mm), size=(50mm, 25.8mm, 5.08mm))
  Port_Rect = rectangle(corner=(0mm, 6.26mm, 0mm), y_size=4.68mm, z_size=1.046mm)
  Vias [pec] = imported_body()
  Rectangle1 = rectangle(corner=(0mm, 7.82mm, 0.508mm), x_size=10mm, y_size=1.56mm)
  Polyline1 = polyline(z=0.508mm, xy in mm: (10, 7.82) (10, 9.38) (13, 10) (13, 7.2) (10, 7.82), closed, covered)
  Rectangle2 = rectangle(corner=(13mm, 0mm, 0.508mm), x_size=27mm, y_size=17.2mm)
  Rectangle3 = rectangle(corner=(19.1mm, 7.85mm, 0.508mm), x_size=14.8mm, y_size=1.5mm)
  Rectangle2.subtract(Rectangle3)
  Rectangle2.unite(Polyline1, Rectangle1)
boundaries and excitations:
  Ground_PEC: Perfect E Objects=Ground
  Rad_Boundary: Radiation Faces=AirBox.face(all 6)
  top_metal: Perfect E Objects=Rectangle2
  port1: Wave Port Objects=Port_Rect WavePortType=Modal NumModes=1 Modes{Mode1{IntLine{(0, 8.6, 0) -> (0, 8.6, 0.508)} CharImp=Zpi}}
setups:
  Setup1: HfssDriven Frequency=8GHz MaxDeltaS=0.02 MaximumPasses=20 MinimumPasses=1 MinimumConvergedPasses=1 PercentRefinement=30 BasisOrder=1 PortAccuracy=2 DrivenSolverType="Direct Solver"
    sweep Sweep1: 6GHz to 12GHz, 121 points; Type=Fast SaveFields
source amplitudes:
  port1:1: 1V 0deg
field plots:
  Mag_E1, Mag_E2: E Field over Rectangle2.face(at (20, 8.6, 0.508)) on Setup1 : LastAdaptive at Freq=8GHz Phase=0deg
